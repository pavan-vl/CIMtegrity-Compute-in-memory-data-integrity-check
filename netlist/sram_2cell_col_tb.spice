** sch_path: /home/paaji/Sky130_prj/sram_2cell_col_tb.sch
**.subckt sram_2cell_col_tb
x1 VDD WL1 BL BLb RWL1 0 RBL sram_8t_bitcell
V1 VDD 0 1.8
V2 WL1 0 PULSE(0 1.8 1n 50p 50p 0.95n 10n)
V3 BL 0 PWL(0 0 10.5n 0 10.55n 1.8 12.5n 1.8 12.55n 0 22.5n 0 22.55n 1.8 40n 1.8)
V4 BLb 0 PWL(0 1.8 10.5n 1.8 10.55n 0 12.5n 0 12.55n 1.8 22.5n 1.8 22.55n 0 40n 0)
V5 PREB 0 PULSE(0 1.8 5n 50p 50p 1.45n 10n)
V6 RWL1 0 PULSE(0 1.8 5.2n 50p 50p 0.65n 10n)
XM1 RBL PREB VDD VDD sky130_fd_pr__pfet_01v8 L=0.15 W=2 nf=1 ad=0.58 as=0.58 pd=4.58 ps=4.58 nrd=0.145 nrs=0.145 sa=0 sb=0 sd=0
+ mult=1
C1 RBL 0 200f
x2 VDD WL2 BL BLb RWL2 0 RBL sram_8t_bitcell
V7 WL2 0 PULSE(0 1.8 3n 50p 50p 0.95n 10n)
V8 RWL2 0 PULSE(0 1.8 5.2n 50p 50p 0.65n 10n)
**** begin user architecture code

.lib /usr/local/share/pdk/sky130A/libs.tech/ngspice/sky130.lib.spice tt
.ic v(x1.q)=0 v(x1.qb)=1.8 v(x2.q)=0 v(x2.qb)=1.8 v(rbl)=1.8
.tran 5p 40n uic
.control
run
meas tran v00 FIND v(rbl) AT=5.9n
meas tran v10 FIND v(rbl) AT=15.9n
meas tran v01 FIND v(rbl) AT=25.9n
meas tran v11 FIND v(rbl) AT=35.9n
let mhigh = v00 - v10
let mlow = v10 - v11
print mhigh mlow
plot v(wl1)+10 v(wl2)+8 v(x1.q)+6 v(x2.q)+4 v(rwl1)+2 v(rbl)
plot v(rbl)
set hcopydevtype=svg
hardcopy step3_all.svg v(wl1)+10 v(wl2)+8 v(x1.q)+6 v(x2.q)+4 v(rwl1)+2 v(rbl)
hardcopy step3_rbl.svg v(rbl)
.endc

**** end user architecture code
**.ends

* expanding   symbol:  sram_8t_bitcell.sym # of pins=7
** sym_path: /home/paaji/Sky130_prj/sram_8t_bitcell.sym
** sch_path: /home/paaji/Sky130_prj/sram_8t_bitcell.sch
.subckt sram_8t_bitcell VDD WL BL BLb RWL VSS RBL
*.iopin VDD
*.ipin WL
*.ipin BL
*.ipin RWL
*.ipin BLb
*.iopin RBL
*.iopin VSS
XM3 Qb Q VSS VSS sky130_fd_pr__nfet_01v8 L=0.15 W=0.84 nf=1 ad=0.2436 as=0.2436 pd=2.26 ps=2.26 nrd=0.345238095238095
+ nrs=0.345238095238095 sa=0 sb=0 sd=0 mult=1
XM1 Q Qb VSS VSS sky130_fd_pr__nfet_01v8 L=0.15 W=0.84 nf=1 ad=0.2436 as=0.2436 pd=2.26 ps=2.26 nrd=0.345238095238095
+ nrs=0.345238095238095 sa=0 sb=0 sd=0 mult=1
XM2 Qb Q VDD VDD sky130_fd_pr__pfet_01v8 L=0.15 W=0.42 nf=1 ad=0.1218 as=0.1218 pd=1.42 ps=1.42 nrd=0.69047619047619
+ nrs=0.69047619047619 sa=0 sb=0 sd=0 mult=1
XM4 Q Qb VDD VDD sky130_fd_pr__pfet_01v8 L=0.15 W=0.42 nf=1 ad=0.1218 as=0.1218 pd=1.42 ps=1.42 nrd=0.69047619047619
+ nrs=0.69047619047619 sa=0 sb=0 sd=0 mult=1
XM5 Q WL BL VSS sky130_fd_pr__nfet_01v8 L=0.15 W=0.42 nf=1 ad=0.1218 as=0.1218 pd=1.42 ps=1.42 nrd=0.69047619047619
+ nrs=0.69047619047619 sa=0 sb=0 sd=0 mult=1
XM6 BLb WL Qb VSS sky130_fd_pr__nfet_01v8 L=0.15 W=0.42 nf=1 ad=0.1218 as=0.1218 pd=1.42 ps=1.42 nrd=0.69047619047619
+ nrs=0.69047619047619 sa=0 sb=0 sd=0 mult=1
XM7 net1 Q VSS VSS sky130_fd_pr__nfet_01v8 L=0.15 W=0.42 nf=1 ad=0.1218 as=0.1218 pd=1.42 ps=1.42 nrd=0.69047619047619
+ nrs=0.69047619047619 sa=0 sb=0 sd=0 mult=1
XM8 RBL RWL net1 VSS sky130_fd_pr__nfet_01v8 L=0.15 W=0.42 nf=1 ad=0.1218 as=0.1218 pd=1.42 ps=1.42 nrd=0.69047619047619
+ nrs=0.69047619047619 sa=0 sb=0 sd=0 mult=1
.ends

.end
