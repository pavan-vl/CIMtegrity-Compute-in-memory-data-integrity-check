** sch_path: /home/paaji/Sky130_prj/strongarm_tb.sch
**.subckt strongarm_tb
xh VDD CLK OUTNH OUTPH VREFH RBL 0 strongarm
xl VDD CLK OUTNL OUTPL VREFL RBL 0 strongarm
V1 VDD 0 1.8
V2 VREFH 0 1.61
V3 VREFL 0 1.24
V4 CLK 0 PULSE(0 1.8 0.5n 50p 50p 0.9n 2n)
V5 RBL 0 PWL(0 1.80 2n 1.80 2.01n 1.65 4n 1.65 4.01n 1.57 6n 1.57 6.01n 1.42 8n 1.42 8.01n 1.28 10n 1.28 10.01n 1.20 12n 1.20
+ 12.01n 1.05 14n 1.05)
**** begin user architecture code

.lib /usr/local/share/pdk/sky130A/libs.tech/ngspice/sky130.lib.spice tt
.tran 5p 14n
.control
run
meas tran h0 FIND v(outph) AT=1.4n
meas tran h1 FIND v(outph) AT=3.4n
meas tran h2 FIND v(outph) AT=5.4n
meas tran h3 FIND v(outph) AT=7.4n
meas tran h4 FIND v(outph) AT=9.4n
meas tran h5 FIND v(outph) AT=11.4n
meas tran h6 FIND v(outph) AT=13.4n
meas tran l0 FIND v(outpl) AT=1.4n
meas tran l1 FIND v(outpl) AT=3.4n
meas tran l2 FIND v(outpl) AT=5.4n
meas tran l3 FIND v(outpl) AT=7.4n
meas tran l4 FIND v(outpl) AT=9.4n
meas tran l5 FIND v(outpl) AT=11.4n
meas tran l6 FIND v(outpl) AT=13.4n
meas tran td_h TRIG v(clk) VAL=0.9 RISE=1 TD=4n TARG v(outph) VAL=0.9 FALL=1 TD=4n
plot v(clk)+6 v(outph)+4 v(outpl)+2 v(rbl)
set hcopydevtype=svg
hardcopy step4_comp.svg v(clk)+6 v(outph)+4 v(outpl)+2 v(rbl)
.endc

**** end user architecture code
**.ends

* expanding   symbol:  strongarm.sym # of pins=7
** sym_path: /home/paaji/Sky130_prj/strongarm.sym
** sch_path: /home/paaji/Sky130_prj/strongarm.sch
.subckt strongarm VDD CLK OUTN OUTP INN INP VSS
*.ipin CLK
*.ipin INP
*.ipin INN
*.opin OUTP
*.opin OUTN
*.iopin VSS
*.iopin VDD
XM7 net1 CLK VSS VSS sky130_fd_pr__nfet_01v8 L=0.15 W=2 nf=1 ad=0.58 as=0.58 pd=4.58 ps=4.58 nrd=0.145 nrs=0.145 sa=0 sb=0 sd=0
+ mult=1
XM1 net3 INP net1 net1 sky130_fd_pr__nfet_01v8 L=0.15 W=2 nf=1 ad=0.58 as=0.58 pd=4.58 ps=4.58 nrd=0.145 nrs=0.145 sa=0 sb=0 sd=0
+ mult=1
XM2 net2 INN net1 net1 sky130_fd_pr__nfet_01v8 L=0.15 W=2 nf=1 ad=0.58 as=0.58 pd=4.58 ps=4.58 nrd=0.145 nrs=0.145 sa=0 sb=0 sd=0
+ mult=1
XM3 OUTN OUTP net3 net3 sky130_fd_pr__nfet_01v8 L=0.15 W=1 nf=1 ad=0.29 as=0.29 pd=2.58 ps=2.58 nrd=0.29 nrs=0.29 sa=0 sb=0 sd=0
+ mult=1
XM4 OUTP OUTN net2 net2 sky130_fd_pr__nfet_01v8 L=0.15 W=1 nf=1 ad=0.29 as=0.29 pd=2.58 ps=2.58 nrd=0.29 nrs=0.29 sa=0 sb=0 sd=0
+ mult=1
XM5 OUTN OUTP VDD VDD sky130_fd_pr__pfet_01v8 L=0.15 W=1 nf=1 ad=0.29 as=0.29 pd=2.58 ps=2.58 nrd=0.29 nrs=0.29 sa=0 sb=0 sd=0
+ mult=1
XM6 OUTP OUTN VDD VDD sky130_fd_pr__pfet_01v8 L=0.15 W=1 nf=1 ad=0.29 as=0.29 pd=2.58 ps=2.58 nrd=0.29 nrs=0.29 sa=0 sb=0 sd=0
+ mult=1
XMS3 OUTN CLK VDD VDD sky130_fd_pr__pfet_01v8 L=0.15 W=0.42 nf=1 ad=0.1218 as=0.1218 pd=1.42 ps=1.42 nrd=0.69047619047619
+ nrs=0.69047619047619 sa=0 sb=0 sd=0 mult=1
XMS1 net3 CLK VDD VDD sky130_fd_pr__pfet_01v8 L=0.15 W=0.42 nf=1 ad=0.1218 as=0.1218 pd=1.42 ps=1.42 nrd=0.69047619047619
+ nrs=0.69047619047619 sa=0 sb=0 sd=0 mult=1
XMS4 OUTP CLK VDD VDD sky130_fd_pr__pfet_01v8 L=0.15 W=0.42 nf=1 ad=0.1218 as=0.1218 pd=1.42 ps=1.42 nrd=0.69047619047619
+ nrs=0.69047619047619 sa=0 sb=0 sd=0 mult=1
XMS2 net2 CLK VDD VDD sky130_fd_pr__pfet_01v8 L=0.15 W=0.42 nf=1 ad=0.1218 as=0.1218 pd=1.42 ps=1.42 nrd=0.69047619047619
+ nrs=0.69047619047619 sa=0 sb=0 sd=0 mult=1
.ends

.end
