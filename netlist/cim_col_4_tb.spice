** sch_path: /home/paaji/Sky130_prj/cim_col_4_tb.sch
**.subckt cim_col_4_tb
VDD VDD 0 1.8
V2 WL1 0 PULSE(0 1.8 1n 50p 50p 0.6n 10n)
V3 WL2 0 PULSE(0 1.8 2n 50p 50p 0.6n 10n)
V4 WL3 0 PULSE(0 1.8 3n 50p 50p 0.6n 10n)
V5 WL4 0 PULSE(0 1.8 4n 50p 50p 0.6n 10n)
V6 PREB 0 PULSE(0 1.8 5n 50p 50p 1.45n 10n)
V7 RWL1 0 PULSE(0 1.8 5.2n 50p 50p 0.4n 10n)
V8 RWL2 0 PULSE(0 1.8 5.2n 50p 50p 0.4n 10n)
V9 RWL3 0 PULSE(0 1.8 5.2n 50p 50p 0.4n 10n)
V10 RWL4 0 PULSE(0 1.8 5.2n 50p 50p 0.4n 10n)
V11 BL 0 PWL(0 0 10.75n 0 10.8n 1.8 11.75n 1.8 11.8n 0 20.75n 0 20.8n 1.8 22.75n 1.8 22.8n 0 30.75n 0 30.8n 1.8 33.75n 1.8 33.8n 0
+ 40.75n 0 40.8n 1.8 50.75n 1.8 50.8n 0 51.75n 0 51.8n 1.8 52.75n 1.8 52.8n 0 53.75n 0 53.8n 1.8 60n 1.8)
V12 BLb 0 PWL(0 1.8 10.75n 1.8 10.8n 0 11.75n 0 11.8n 1.8 20.75n 1.8 20.8n 0 22.75n 0 22.8n 1.8 30.75n 1.8 30.8n 0 33.75n 0 33.8n
+ 1.8 40.75n 1.8 40.8n 0 50.75n 0 50.8n 1.8 51.75n 1.8 51.8n 0 52.75n 0 52.8n 1.8 53.75n 1.8 53.8n 0 60n 0)
C1 RBL 0 200f
XM1 RBL PREB VDD VDD sky130_fd_pr__pfet_01v8 L=0.15 W=1 nf=1 ad=0.29 as=0.29 pd=2.58 ps=2.58 nrd=0.29 nrs=0.29 sa=0 sb=0 sd=0
+ mult=1
xcol WL1 VDD BL BLb RBL RWL1 WL2 RWL2 WL3 RWL3 WL4 RWL4 0 single_col_4cell
xs VDD SAE VREF1 VREF3 VREF2 RBL VREF4 NT4 net1 net2 net3 NT2 0 T1 T2 T3 sense4
xt VDD T3 T1 T2 NT4 NT2 0 B0 B1 B2 therm_to_bin
V1 VREF1 0 1.673
V13 VREF2 0 1.430
V14 VREF3 0 1.188
V15 VREF4 0 0.952
V16 SAE 0 PULSE(0 1.8 5.75n 50p 50p 0.45n 10n)
**** begin user architecture code

.lib /usr/local/share/pdk/sky130A/libs.tech/ngspice/sky130.lib.spice tt
.ic v(xcol.x1.q)=0 v(xcol.x1.qb)=1.8 v(xcol.x2.q)=0 v(xcol.x2.qb)=1.8 v(xcol.x3.q)=0 v(xcol.x3.qb)=1.8 v(xcol.x4.q)=0 v(xcol.x4.qb)=1.8 v(rbl)=1.8
.tran 5p 60n uic
.control
run
meas tran p0_b2 FIND v(b2) AT=9.5n
meas tran p0_b1 FIND v(b1) AT=9.5n
meas tran p0_b0 FIND v(b0) AT=9.5n
meas tran p1_b2 FIND v(b2) AT=19.5n
meas tran p1_b1 FIND v(b1) AT=19.5n
meas tran p1_b0 FIND v(b0) AT=19.5n
meas tran p2_b2 FIND v(b2) AT=29.5n
meas tran p2_b1 FIND v(b1) AT=29.5n
meas tran p2_b0 FIND v(b0) AT=29.5n
meas tran p3_b2 FIND v(b2) AT=39.5n
meas tran p3_b1 FIND v(b1) AT=39.5n
meas tran p3_b0 FIND v(b0) AT=39.5n
meas tran p4_b2 FIND v(b2) AT=49.5n
meas tran p4_b1 FIND v(b1) AT=49.5n
meas tran p4_b0 FIND v(b0) AT=49.5n
meas tran p5_b2 FIND v(b2) AT=59.5n
meas tran p5_b1 FIND v(b1) AT=59.5n
meas tran p5_b0 FIND v(b0) AT=59.5n
meas tran q0 INTEG i(vdd) FROM=5n TO=10n
meas tran q4 INTEG i(vdd) FROM=45n TO=50n
let e0 = -1.8*q0
let e4 = -1.8*q4
print e0 e4
meas tran tlat TRIG v(rwl1) VAL=0.9 RISE=1 TD=45n TARG v(b2) VAL=0.9 RISE=1 TD=45n
plot v(sae)+8 v(b2)+6 v(b1)+4 v(b0)+2 v(rbl)
.endc

**** end user architecture code
**.ends

* expanding   symbol:  single_col_4cell.sym # of pins=13
** sym_path: /home/paaji/Sky130_prj/single_col_4cell.sym
** sch_path: /home/paaji/Sky130_prj/single_col_4cell.sch
.subckt single_col_4cell WL1 VDD BL BLb RBL RWL1 WL2 RWL2 WL3 RWL3 WL4 RWL4 VSS
*.ipin RWL4
*.ipin WL4
*.ipin WL3
*.ipin RWL3
*.ipin WL2
*.ipin RWL2
*.ipin WL1
*.ipin RWL1
*.ipin BL
*.ipin BLb
*.iopin VDD
*.iopin RBL
*.iopin VSS
x1 VDD WL1 BL BLb RWL1 VSS RBL sram_8t_bitcell
x2 VDD WL2 BL BLb RWL2 VSS RBL sram_8t_bitcell
x3 VDD WL3 BL BLb RWL3 VSS RBL sram_8t_bitcell
x4 VDD WL4 BL BLb RWL4 VSS RBL sram_8t_bitcell
.ends

* expanding   symbol:  sense4.sym # of pins=16
** sym_path: /home/paaji/Sky130_prj/sense4.sym
** sch_path: /home/paaji/Sky130_prj/sense4.sch
.subckt sense4 VDD SAE VREF1 VREF3 VREF2 RBL VREF4 NT4 T4 NT1 NT3 NT2 VSS T1 T2 T3
*.ipin SAE
*.ipin RBL
*.ipin VREF1
*.ipin VREF2
*.ipin VREF3
*.ipin VREF4
*.iopin VDD
*.iopin VSS
*.opin T1
*.opin NT1
*.opin NT2
*.opin T2
*.opin T3
*.opin NT3
*.opin T4
*.opin NT4
xs1 VDD SAE ON1 OP1 VREF1 RBL VSS strongarm
xs2 VDD SAE ON2 OP2 VREF2 RBL VSS strongarm
xs3 VDD SAE ON3 OP3 VREF3 RBL VSS strongarm
xs4 VDD SAE ON4 OP4 VREF4 RBL VSS strongarm
xl1 VDD ON1 NT1 T1 OP1 VSS sr_latch
xl2 VDD ON2 NT2 T2 OP2 VSS sr_latch
xl3 VDD ON3 NT3 T3 OP3 VSS sr_latch
xl4 VDD ON4 NT4 T4 OP4 VSS sr_latch
.ends

* expanding   symbol:  therm_to_bin.sym # of pins=10
** sym_path: /home/paaji/Sky130_prj/therm_to_bin.sym
** sch_path: /home/paaji/Sky130_prj/therm_to_bin.sch
.subckt therm_to_bin VDD T3 T1 T2 NT4 NT2 VSS B0 B1 B2
*.ipin T1
*.ipin NT2
*.ipin T3
*.ipin NT4
*.opin B0
*.ipin T2
*.iopin VDD
*.iopin VSS
*.opin B2
*.opin B1
xa VDD T1 N1 NT2 VSS nand2
xb VDD T3 N2 NT4 VSS nand2
xc VDD N1 B0 N2 VSS nand2
xd VDD T2 N3 NT4 VSS nand2
xf VDD NT4 B2 VSS inv
x2 VDD N3 B1 VSS inv
.ends

* expanding   symbol:  sram_8t_bitcell.sym # of pins=7
** sym_path: /home/paaji/Sky130_prj/sram_8t_bitcell.sym
** sch_path: /home/paaji/Sky130_prj/sram_8t_bitcell.sch
.subckt sram_8t_bitcell VDD WL BL BLb RWL VSS RBL
*.iopin VDD
*.ipin WL
*.ipin BL
*.ipin RWL
*.ipin BLb
*.iopin RBL
*.iopin VSS
XM3 Qb Q VSS VSS sky130_fd_pr__nfet_01v8 L=0.15 W=0.84 nf=1 ad=0.2436 as=0.2436 pd=2.26 ps=2.26 nrd=0.345238095238095
+ nrs=0.345238095238095 sa=0 sb=0 sd=0 mult=1
XM1 Q Qb VSS VSS sky130_fd_pr__nfet_01v8 L=0.15 W=0.84 nf=1 ad=0.2436 as=0.2436 pd=2.26 ps=2.26 nrd=0.345238095238095
+ nrs=0.345238095238095 sa=0 sb=0 sd=0 mult=1
XM2 Qb Q VDD VDD sky130_fd_pr__pfet_01v8 L=0.15 W=0.42 nf=1 ad=0.1218 as=0.1218 pd=1.42 ps=1.42 nrd=0.69047619047619
+ nrs=0.69047619047619 sa=0 sb=0 sd=0 mult=1
XM4 Q Qb VDD VDD sky130_fd_pr__pfet_01v8 L=0.15 W=0.42 nf=1 ad=0.1218 as=0.1218 pd=1.42 ps=1.42 nrd=0.69047619047619
+ nrs=0.69047619047619 sa=0 sb=0 sd=0 mult=1
XM5 Q WL BL VSS sky130_fd_pr__nfet_01v8 L=0.15 W=0.42 nf=1 ad=0.1218 as=0.1218 pd=1.42 ps=1.42 nrd=0.69047619047619
+ nrs=0.69047619047619 sa=0 sb=0 sd=0 mult=1
XM6 BLb WL Qb VSS sky130_fd_pr__nfet_01v8 L=0.15 W=0.42 nf=1 ad=0.1218 as=0.1218 pd=1.42 ps=1.42 nrd=0.69047619047619
+ nrs=0.69047619047619 sa=0 sb=0 sd=0 mult=1
XM7 net1 Q VSS VSS sky130_fd_pr__nfet_01v8 L=0.15 W=0.42 nf=1 ad=0.1218 as=0.1218 pd=1.42 ps=1.42 nrd=0.69047619047619
+ nrs=0.69047619047619 sa=0 sb=0 sd=0 mult=1
XM8 RBL RWL net1 VSS sky130_fd_pr__nfet_01v8 L=0.15 W=0.42 nf=1 ad=0.1218 as=0.1218 pd=1.42 ps=1.42 nrd=0.69047619047619
+ nrs=0.69047619047619 sa=0 sb=0 sd=0 mult=1
.ends

* expanding   symbol:  strongarm.sym # of pins=7
** sym_path: /home/paaji/Sky130_prj/strongarm.sym
** sch_path: /home/paaji/Sky130_prj/strongarm.sch
.subckt strongarm VDD CLK OUTN OUTP INN INP VSS
*.ipin CLK
*.ipin INP
*.ipin INN
*.opin OUTP
*.opin OUTN
*.iopin VSS
*.iopin VDD
XM7 net1 CLK VSS VSS sky130_fd_pr__nfet_01v8 L=0.15 W=2 nf=1 ad=0.58 as=0.58 pd=4.58 ps=4.58 nrd=0.145 nrs=0.145 sa=0 sb=0 sd=0
+ mult=1
XM1 net3 INP net1 net1 sky130_fd_pr__nfet_01v8 L=0.15 W=2 nf=1 ad=0.58 as=0.58 pd=4.58 ps=4.58 nrd=0.145 nrs=0.145 sa=0 sb=0 sd=0
+ mult=1
XM2 net2 INN net1 net1 sky130_fd_pr__nfet_01v8 L=0.15 W=2 nf=1 ad=0.58 as=0.58 pd=4.58 ps=4.58 nrd=0.145 nrs=0.145 sa=0 sb=0 sd=0
+ mult=1
XM3 OUTN OUTP net3 net3 sky130_fd_pr__nfet_01v8 L=0.15 W=1 nf=1 ad=0.29 as=0.29 pd=2.58 ps=2.58 nrd=0.29 nrs=0.29 sa=0 sb=0 sd=0
+ mult=1
XM4 OUTP OUTN net2 net2 sky130_fd_pr__nfet_01v8 L=0.15 W=1 nf=1 ad=0.29 as=0.29 pd=2.58 ps=2.58 nrd=0.29 nrs=0.29 sa=0 sb=0 sd=0
+ mult=1
XM5 OUTN OUTP VDD VDD sky130_fd_pr__pfet_01v8 L=0.15 W=2 nf=1 ad=0.58 as=0.58 pd=4.58 ps=4.58 nrd=0.145 nrs=0.145 sa=0 sb=0 sd=0
+ mult=1
XM6 OUTP OUTN VDD VDD sky130_fd_pr__pfet_01v8 L=0.15 W=2 nf=1 ad=0.58 as=0.58 pd=4.58 ps=4.58 nrd=0.145 nrs=0.145 sa=0 sb=0 sd=0
+ mult=1
XMS3 OUTN CLK VDD VDD sky130_fd_pr__pfet_01v8 L=0.15 W=0.42 nf=1 ad=0.1218 as=0.1218 pd=1.42 ps=1.42 nrd=0.69047619047619
+ nrs=0.69047619047619 sa=0 sb=0 sd=0 mult=1
XMS1 net3 CLK VDD VDD sky130_fd_pr__pfet_01v8 L=0.15 W=0.42 nf=1 ad=0.1218 as=0.1218 pd=1.42 ps=1.42 nrd=0.69047619047619
+ nrs=0.69047619047619 sa=0 sb=0 sd=0 mult=1
XMS4 OUTP CLK VDD VDD sky130_fd_pr__pfet_01v8 L=0.15 W=0.42 nf=1 ad=0.1218 as=0.1218 pd=1.42 ps=1.42 nrd=0.69047619047619
+ nrs=0.69047619047619 sa=0 sb=0 sd=0 mult=1
XMS2 net2 CLK VDD VDD sky130_fd_pr__pfet_01v8 L=0.15 W=0.42 nf=1 ad=0.1218 as=0.1218 pd=1.42 ps=1.42 nrd=0.69047619047619
+ nrs=0.69047619047619 sa=0 sb=0 sd=0 mult=1
.ends

* expanding   symbol:  sr_latch.sym # of pins=6
** sym_path: /home/paaji/Sky130_prj/sr_latch.sym
** sch_path: /home/paaji/Sky130_prj/sr_latch.sch
.subckt sr_latch VDD SB Q QB RB VSS
*.iopin VDD
*.iopin VSS
*.ipin SB
*.ipin RB
*.opin Q
*.opin QB
xn1 VDD SB Q QB VSS nand2
xn2 VDD Q QB RB VSS nand2
.ends

* expanding   symbol:  nand2.sym # of pins=5
** sym_path: /home/paaji/Sky130_prj/nand2.sym
** sch_path: /home/paaji/Sky130_prj/nand2.sch
.subckt nand2 VDD A Y B VSS
*.ipin A
*.ipin B
*.opin Y
*.iopin VDD
*.iopin VSS
XM1 net1 B VSS VSS sky130_fd_pr__nfet_01v8 L=0.15 W=0.84 nf=1 ad=0.2436 as=0.2436 pd=2.26 ps=2.26 nrd=0.345238095238095
+ nrs=0.345238095238095 sa=0 sb=0 sd=0 mult=1
XM2 Y B VDD VDD sky130_fd_pr__pfet_01v8 L=0.15 W=0.84 nf=1 ad=0.2436 as=0.2436 pd=2.26 ps=2.26 nrd=0.345238095238095
+ nrs=0.345238095238095 sa=0 sb=0 sd=0 mult=1
XM3 Y A VDD VDD sky130_fd_pr__pfet_01v8 L=0.15 W=0.84 nf=1 ad=0.2436 as=0.2436 pd=2.26 ps=2.26 nrd=0.345238095238095
+ nrs=0.345238095238095 sa=0 sb=0 sd=0 mult=1
XM4 Y A net1 net1 sky130_fd_pr__nfet_01v8 L=0.15 W=0.84 nf=1 ad=0.2436 as=0.2436 pd=2.26 ps=2.26 nrd=0.345238095238095
+ nrs=0.345238095238095 sa=0 sb=0 sd=0 mult=1
.ends

* expanding   symbol:  inv.sym # of pins=4
** sym_path: /home/paaji/Sky130_prj/inv.sym
** sch_path: /home/paaji/Sky130_prj/inv.sch
.subckt inv VDD A Y VSS
*.ipin A
*.opin Y
*.iopin VDD
*.iopin VSS
XM1 Y A VSS VSS sky130_fd_pr__nfet_01v8 L=0.15 W=0.42 nf=1 ad=0.1218 as=0.1218 pd=1.42 ps=1.42 nrd=0.69047619047619
+ nrs=0.69047619047619 sa=0 sb=0 sd=0 mult=1
XM2 Y A VDD VDD sky130_fd_pr__pfet_01v8 L=0.15 W=0.84 nf=1 ad=0.2436 as=0.2436 pd=2.26 ps=2.26 nrd=0.345238095238095
+ nrs=0.345238095238095 sa=0 sb=0 sd=0 mult=1
.ends

.end
