** sch_path: /home/paaji/Sky130_prj/therm_to_bin.sch
**.subckt therm_to_bin VDD T3 T1 T2 NT4 NT2 VSS B0 B1 B2
*.ipin T1
*.ipin NT2
*.ipin T3
*.ipin NT4
*.opin B0
*.ipin T2
*.iopin VDD
*.iopin VSS
*.opin B2
*.opin B1
xa VDD T1 N1 NT2 VSS nand2
xb VDD T3 N2 NT4 VSS nand2
xc VDD N1 B0 N2 VSS nand2
xd VDD T2 N3 NT4 VSS nand2
xf VDD NT4 B2 VSS inv
x2 VDD N3 B1 VSS inv
**.ends

* expanding   symbol:  nand2.sym # of pins=5
** sym_path: /home/paaji/Sky130_prj/nand2.sym
** sch_path: /home/paaji/Sky130_prj/nand2.sch
.subckt nand2 VDD A Y B VSS
*.ipin A
*.ipin B
*.opin Y
*.iopin VDD
*.iopin VSS
XM1 net1 B VSS VSS sky130_fd_pr__nfet_01v8 L=0.15 W=0.84 nf=1 ad=0.2436 as=0.2436 pd=2.26 ps=2.26 nrd=0.345238095238095
+ nrs=0.345238095238095 sa=0 sb=0 sd=0 mult=1
XM2 Y B VDD VDD sky130_fd_pr__pfet_01v8 L=0.15 W=0.84 nf=1 ad=0.2436 as=0.2436 pd=2.26 ps=2.26 nrd=0.345238095238095
+ nrs=0.345238095238095 sa=0 sb=0 sd=0 mult=1
XM3 Y A VDD VDD sky130_fd_pr__pfet_01v8 L=0.15 W=0.84 nf=1 ad=0.2436 as=0.2436 pd=2.26 ps=2.26 nrd=0.345238095238095
+ nrs=0.345238095238095 sa=0 sb=0 sd=0 mult=1
XM4 Y A net1 net1 sky130_fd_pr__nfet_01v8 L=0.15 W=0.84 nf=1 ad=0.2436 as=0.2436 pd=2.26 ps=2.26 nrd=0.345238095238095
+ nrs=0.345238095238095 sa=0 sb=0 sd=0 mult=1
.ends

* expanding   symbol:  inv.sym # of pins=4
** sym_path: /home/paaji/Sky130_prj/inv.sym
** sch_path: /home/paaji/Sky130_prj/inv.sch
.subckt inv VDD A Y VSS
*.ipin A
*.opin Y
*.iopin VDD
*.iopin VSS
XM1 Y A VSS VSS sky130_fd_pr__nfet_01v8 L=0.15 W=0.42 nf=1 ad=0.1218 as=0.1218 pd=1.42 ps=1.42 nrd=0.69047619047619
+ nrs=0.69047619047619 sa=0 sb=0 sd=0 mult=1
XM2 Y A VDD VDD sky130_fd_pr__pfet_01v8 L=0.15 W=0.84 nf=1 ad=0.2436 as=0.2436 pd=2.26 ps=2.26 nrd=0.345238095238095
+ nrs=0.345238095238095 sa=0 sb=0 sd=0 mult=1
.ends

.end
