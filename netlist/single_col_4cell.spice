** sch_path: /home/paaji/Sky130_prj/single_col_4cell.sch
**.subckt single_col_4cell RWL4 WL4 WL3 RWL3 WL2 RWL2 WL1 RWL1 BL BLb VDD RBL VSS
*.ipin RWL4
*.ipin WL4
*.ipin WL3
*.ipin RWL3
*.ipin WL2
*.ipin RWL2
*.ipin WL1
*.ipin RWL1
*.ipin BL
*.ipin BLb
*.iopin VDD
*.iopin RBL
*.iopin VSS
x1 VDD WL1 BL BLb RWL1 VSS RBL sram_8t_bitcell
x2 VDD WL2 BL BLb RWL2 VSS RBL sram_8t_bitcell
x3 VDD WL3 BL BLb RWL3 VSS RBL sram_8t_bitcell
x4 VDD WL4 BL BLb RWL4 VSS RBL sram_8t_bitcell
**.ends

* expanding   symbol:  sram_8t_bitcell.sym # of pins=7
** sym_path: /home/paaji/Sky130_prj/sram_8t_bitcell.sym
** sch_path: /home/paaji/Sky130_prj/sram_8t_bitcell.sch
.subckt sram_8t_bitcell VDD WL BL BLb RWL VSS RBL
*.iopin VDD
*.ipin WL
*.ipin BL
*.ipin RWL
*.ipin BLb
*.iopin RBL
*.iopin VSS
XM3 Qb Q VSS VSS sky130_fd_pr__nfet_01v8 L=0.15 W=0.84 nf=1 ad=0.2436 as=0.2436 pd=2.26 ps=2.26 nrd=0.345238095238095
+ nrs=0.345238095238095 sa=0 sb=0 sd=0 mult=1
XM1 Q Qb VSS VSS sky130_fd_pr__nfet_01v8 L=0.15 W=0.84 nf=1 ad=0.2436 as=0.2436 pd=2.26 ps=2.26 nrd=0.345238095238095
+ nrs=0.345238095238095 sa=0 sb=0 sd=0 mult=1
XM2 Qb Q VDD VDD sky130_fd_pr__pfet_01v8 L=0.15 W=0.42 nf=1 ad=0.1218 as=0.1218 pd=1.42 ps=1.42 nrd=0.69047619047619
+ nrs=0.69047619047619 sa=0 sb=0 sd=0 mult=1
XM4 Q Qb VDD VDD sky130_fd_pr__pfet_01v8 L=0.15 W=0.42 nf=1 ad=0.1218 as=0.1218 pd=1.42 ps=1.42 nrd=0.69047619047619
+ nrs=0.69047619047619 sa=0 sb=0 sd=0 mult=1
XM5 Q WL BL VSS sky130_fd_pr__nfet_01v8 L=0.15 W=0.42 nf=1 ad=0.1218 as=0.1218 pd=1.42 ps=1.42 nrd=0.69047619047619
+ nrs=0.69047619047619 sa=0 sb=0 sd=0 mult=1
XM6 BLb WL Qb VSS sky130_fd_pr__nfet_01v8 L=0.15 W=0.42 nf=1 ad=0.1218 as=0.1218 pd=1.42 ps=1.42 nrd=0.69047619047619
+ nrs=0.69047619047619 sa=0 sb=0 sd=0 mult=1
XM7 net1 Q VSS VSS sky130_fd_pr__nfet_01v8 L=0.15 W=0.42 nf=1 ad=0.1218 as=0.1218 pd=1.42 ps=1.42 nrd=0.69047619047619
+ nrs=0.69047619047619 sa=0 sb=0 sd=0 mult=1
XM8 RBL RWL net1 VSS sky130_fd_pr__nfet_01v8 L=0.15 W=0.42 nf=1 ad=0.1218 as=0.1218 pd=1.42 ps=1.42 nrd=0.69047619047619
+ nrs=0.69047619047619 sa=0 sb=0 sd=0 mult=1
.ends

.end
