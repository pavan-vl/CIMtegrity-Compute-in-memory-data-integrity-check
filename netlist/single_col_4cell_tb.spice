** sch_path: /home/paaji/Sky130_prj/single_col_4cell_tb.sch
**.subckt single_col_4cell_tb
V1 VDD 0 1.8
V2 WL1 0 PULSE(0 1.8 1n 50p 50p 0.6n 10n)
V3 WL2 0 PULSE(0 1.8 2n 50p 50p 0.6n 10n)
V4 WL3 0 PULSE(0 1.8 3n 50p 50p 0.6n 10n)
V5 WL4 0 PULSE(0 1.8 4n 50p 50p 0.6n 10n)
V6 PREB 0 PULSE(0 1.8 5n 50p 50p 1.45n 10n)
V7 RWL1 0 PULSE(0 1.8 5.2n 50p 50p 0.4n 10n)
V8 RWL2 0 PULSE(0 1.8 5.2n 50p 50p 0.4n 10n)
V9 RWL3 0 PULSE(0 1.8 5.2n 50p 50p 0.4n 10n)
V10 RWL4 0 PULSE(0 1.8 5.2n 50p 50p 0.4n 10n)
V11 BL 0 PWL(0 0 10.75n 0 10.8n 1.8 11.75n 1.8 11.8n 0 20.75n 0 20.8n 1.8 22.75n 1.8 22.8n 0 30.75n 0 30.8n 1.8 33.75n 1.8 33.8n 0
+ 40.75n 0 40.8n 1.8 50.75n 1.8 50.8n 0 51.75n 0 51.8n 1.8 52.75n 1.8 52.8n 0 53.75n 0 53.8n 1.8 60n 1.8)
V12 BLb 0 PWL(0 1.8 10.75n 1.8 10.8n 0 11.75n 0 11.8n 1.8 20.75n 1.8 20.8n 0 22.75n 0 22.8n 1.8 30.75n 1.8 30.8n 0 33.75n 0 33.8n
+ 1.8 40.75n 1.8 40.8n 0 50.75n 0 50.8n 1.8 51.75n 1.8 51.8n 0 52.75n 0 52.8n 1.8 53.75n 1.8 53.8n 0 60n 0)
C1 RBL 0 200f
XM1 RBL PREB VDD VDD sky130_fd_pr__pfet_01v8 L=0.15 W=1 nf=1 ad=0.29 as=0.29 pd=2.58 ps=2.58 nrd=0.29 nrs=0.29 sa=0 sb=0 sd=0
+ mult=1
xcol WL1 VDD BL BLb RBL RWL1 WL2 RWL2 WL3 RWL3 WL4 RWL4 0 single_col_4cell
**** begin user architecture code

.lib /usr/local/share/pdk/sky130A/libs.tech/ngspice/sky130.lib.spice tt
.ic v(xcol.x1.q)=0 v(xcol.x1.qb)=1.8 v(xcol.x2.q)=0 v(xcol.x2.qb)=1.8 v(xcol.x3.q)=0 v(xcol.x3.qb)=1.8 v(xcol.x4.q)=0 v(xcol.x4.qb)=1.8 v(rbl)=1.8
.tran 5p 60n uic
.control
run
meas tran p0a FIND v(rbl) AT=5.65n
meas tran p0b FIND v(rbl) AT=5.9n
meas tran p1a FIND v(rbl) AT=15.65n
meas tran p1b FIND v(rbl) AT=15.9n
meas tran p2a FIND v(rbl) AT=25.65n
meas tran p2b FIND v(rbl) AT=25.9n
meas tran p3a FIND v(rbl) AT=35.65n
meas tran p3b FIND v(rbl) AT=35.9n
meas tran p4a FIND v(rbl) AT=45.65n
meas tran p4b FIND v(rbl) AT=45.9n
meas tran p5a FIND v(rbl) AT=55.65n
meas tran p5b FIND v(rbl) AT=55.9n
plot v(xcol.x1.q)+14 v(xcol.x2.q)+12 v(xcol.x3.q)+10 v(xcol.x4.q)+8 v(rwl1)+6 v(preb)+4 v(rbl)
plot v(rbl)
.endc

**** end user architecture code
**.ends

* expanding   symbol:  single_col_4cell.sym # of pins=13
** sym_path: /home/paaji/Sky130_prj/single_col_4cell.sym
** sch_path: /home/paaji/Sky130_prj/single_col_4cell.sch
.subckt single_col_4cell WL1 VDD BL BLb RBL RWL1 WL2 RWL2 WL3 RWL3 WL4 RWL4 VSS
*.ipin RWL4
*.ipin WL4
*.ipin WL3
*.ipin RWL3
*.ipin WL2
*.ipin RWL2
*.ipin WL1
*.ipin RWL1
*.ipin BL
*.ipin BLb
*.iopin VDD
*.iopin RBL
*.iopin VSS
x1 VDD WL1 BL BLb RWL1 VSS RBL sram_8t_bitcell
x2 VDD WL2 BL BLb RWL2 VSS RBL sram_8t_bitcell
x3 VDD WL3 BL BLb RWL3 VSS RBL sram_8t_bitcell
x4 VDD WL4 BL BLb RWL4 VSS RBL sram_8t_bitcell
.ends

* expanding   symbol:  sram_8t_bitcell.sym # of pins=7
** sym_path: /home/paaji/Sky130_prj/sram_8t_bitcell.sym
** sch_path: /home/paaji/Sky130_prj/sram_8t_bitcell.sch
.subckt sram_8t_bitcell VDD WL BL BLb RWL VSS RBL
*.iopin VDD
*.ipin WL
*.ipin BL
*.ipin RWL
*.ipin BLb
*.iopin RBL
*.iopin VSS
XM3 Qb Q VSS VSS sky130_fd_pr__nfet_01v8 L=0.15 W=0.84 nf=1 ad=0.2436 as=0.2436 pd=2.26 ps=2.26 nrd=0.345238095238095
+ nrs=0.345238095238095 sa=0 sb=0 sd=0 mult=1
XM1 Q Qb VSS VSS sky130_fd_pr__nfet_01v8 L=0.15 W=0.84 nf=1 ad=0.2436 as=0.2436 pd=2.26 ps=2.26 nrd=0.345238095238095
+ nrs=0.345238095238095 sa=0 sb=0 sd=0 mult=1
XM2 Qb Q VDD VDD sky130_fd_pr__pfet_01v8 L=0.15 W=0.42 nf=1 ad=0.1218 as=0.1218 pd=1.42 ps=1.42 nrd=0.69047619047619
+ nrs=0.69047619047619 sa=0 sb=0 sd=0 mult=1
XM4 Q Qb VDD VDD sky130_fd_pr__pfet_01v8 L=0.15 W=0.42 nf=1 ad=0.1218 as=0.1218 pd=1.42 ps=1.42 nrd=0.69047619047619
+ nrs=0.69047619047619 sa=0 sb=0 sd=0 mult=1
XM5 Q WL BL VSS sky130_fd_pr__nfet_01v8 L=0.15 W=0.42 nf=1 ad=0.1218 as=0.1218 pd=1.42 ps=1.42 nrd=0.69047619047619
+ nrs=0.69047619047619 sa=0 sb=0 sd=0 mult=1
XM6 BLb WL Qb VSS sky130_fd_pr__nfet_01v8 L=0.15 W=0.42 nf=1 ad=0.1218 as=0.1218 pd=1.42 ps=1.42 nrd=0.69047619047619
+ nrs=0.69047619047619 sa=0 sb=0 sd=0 mult=1
XM7 net1 Q VSS VSS sky130_fd_pr__nfet_01v8 L=0.15 W=0.42 nf=1 ad=0.1218 as=0.1218 pd=1.42 ps=1.42 nrd=0.69047619047619
+ nrs=0.69047619047619 sa=0 sb=0 sd=0 mult=1
XM8 RBL RWL net1 VSS sky130_fd_pr__nfet_01v8 L=0.15 W=0.42 nf=1 ad=0.1218 as=0.1218 pd=1.42 ps=1.42 nrd=0.69047619047619
+ nrs=0.69047619047619 sa=0 sb=0 sd=0 mult=1
.ends

.end
